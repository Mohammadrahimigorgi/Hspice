 Project 1 - Simple Voltage Divider

V1 vin 0 DC 5

R1 vin vout 10k
R2 vout 0 10k

.op

.print DC V(vin) V(vout)

.end
